# Ansys Electronics Desktop project, version 2022.2
materials:
  vacuum: permittivity=1

design HFSSDesign1 (HFSS, DrivenModal, model units in)
geometry:
  waveguide = box(corner=(-0.795in, -0.3975in, 0in), size=(1.59in, 0.795in, 1in))
  face = rectangle(corner=(-3.975in, -1.987in, 5in), x_size=7.95in, y_size=3.975in)
  face_ObjectFromFace1 [vacuum] = object_from(face.face(at (0, 0.0005, 5)))
  waveguide_ObjectFromFace1 = object_from(face_ObjectFromFace1.face(1 of 6))
  face_ObjectFromFace1.connect(waveguide_ObjectFromFace1)
  face_ObjectFromFace1.uncover_faces(FacesToUncover=face_ObjectFromFace1.face(at (0, 0.0005, 5)))
  face.uncover_faces(FacesToUncover=face.face(at (0, 0.0005, 5)))
  face_ObjectFromFace1.uncover_faces(FacesToUncover=waveguide_ObjectFromFace1.face)
  waveguide.uncover_faces(FacesToUncover=face_ObjectFromFace1.face(1 of 6))
  face_ObjectFromFace1.unite(waveguide)
  radiation [vacuum] = box(corner=(-4.4in, -2.2in, 0in), size=(8.8in, 4.4in, 15in))
boundaries and excitations:
  PerfE1: Perfect E Objects=face_ObjectFromFace1
  Rad1: Radiation Objects=radiation
  1: Wave Port Faces=face_ObjectFromFace1.face(2 of 6) NumModes=1 Modes{Mode1{IntLine{(0, 0.3975, 0) -> (0, -0.3975, 0)} CharImp=Zpi}}
setups:
  Setup1: HfssDriven Frequency=5GHz MaxDeltaS=0.02 MaximumPasses=25 MinimumPasses=1 MinimumConvergedPasses=1 PercentRefinement=30 BasisOrder=1 PortAccuracy=2 DrivenSolverType="Direct Solver"
    sweep Sweep: 4GHz to 8GHz step 0.02GHz; Type=Fast SaveFields
source amplitudes:
  1:1: 1W 0deg
radiation setups:
  Infinite Sphere1: Infinite Sphere Theta=-180deg..180deg step 1deg Phi=0deg..180deg step 1deg
reports:
  S Parameter Plot 1: dB(S(1,1)) vs Freq on Setup1 : Sweep
  VSWR Plot 1: VSWR(1) vs Freq on Setup1 : Sweep
  S Parameter Plot 2: dB(S(1,1)) vs Freq, Freq on Setup1 : Sweep
  Gain Plot 1: GainTotal vs Phi, Theta on Setup1 : LastAdaptive, Infinite Sphere1 [Freq=5GHz]
